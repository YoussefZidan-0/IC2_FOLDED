ADE simulation setup
Run mode: Single Run, Sweeps and Corners
Tests:
  proj2:CMOS_LUT_GMID:1: proj2/CMOS_LUT_GMID/schematic, simulator spectre
Global variables:
  L_n = 0.5u:0.5u:4u
  L_p = 0.5u:0.5u:4u
  Vdn = 1.7
  Vdp = 1.7
  Vgn = 1
  Vgp = 1
  W_n = 10u
  W_p = 10u
  Vg = 1
