ADE simulation setup
Run mode: Single Run, Sweeps and Corners
Tests:
  proj2:FOLDED:1: proj2/FOLDED/schematic, simulator spectre
Global variables:
  ISS = 134.000u
  L_in = 0.5u
  Ln_Cascode = 0.6u
  Ln_Mirror = 1u
  Lp_Cascode = 0.6u
  Lp_Mirror = Ln_Mirror
  Vb1 = 2.52289
  Vb2 = 2.42156
  Vb3 = 0.863896
  W_in = 31.2044u
  Wn_Cascode = 20.27u
  Wn_Mirror = 11.579u
  Wp_Cascode = 52.3u
  Wp_Mirror = 108.34u
