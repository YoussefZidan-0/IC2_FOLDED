ADE simulation setup
Run mode: Single Run, Sweeps and Corners
Tests:
  proj2:FOLDED:1: proj2/FOLDED/schematic, simulator spectre
Global variables:
  ISS = 134.000u
  L_in = 0.5u
  Ln_Cascode = 0.5u
  Ln_Mirror = 1u
  Lp_Cascode = 0.4u
  Lp_Mirror = Ln_Mirror
  Vb1 = 2.5
  Vb2 = 1.4
  Vb3 = 1.2
  W_in = 50u
  Wn_Cascode = 20.27u
  Wn_Mirror = 9u
  Wp_Cascode = 52.3u
  Wp_Mirror = 114u
  VICM = 1.65
Specs:
  proj2:FOLDED:1 / GBW: > 150M
  proj2:FOLDED:1 / Ao_dB: > 58
  proj2:FOLDED:1 / slewRate(v("/Vout" ?result "ac") 0.25 t 0.8 t 10 90 nil "time"): > 0.1G
  proj2:FOLDED:1 / Fu: > 150M
  proj2:FOLDED:1 / PM: > 60
  proj2:FOLDED:1 / GM: > 12
